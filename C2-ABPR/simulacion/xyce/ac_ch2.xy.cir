* ac_ch2

Vb vb 0 1.32
Ict vb t AC 1
Rb t vb 47
R5 t a 3.3k
C5 a 0 47n
.ac dec 200 10 20k

.model BAT85 D(IS=1.3e-8 N=1.1 RS=2 CJO=10p BV=30 IBV=2u)
.model D1N5819 D(IS=31.7u N=1.373 RS=0.051 CJO=110p M=0.35 EG=0.69 XTI=2 BV=40 IBV=1m)

.options device temp=27 tnom=27
.options timeint reltol=1e-6 abstol=1e-12
.print AC format=csv precision=12 file=ac_ch2.xy.csv vm(a) vp(a)
.end
