* alim_5_0

Vad in 0 5.0
Rptc in p 0.15
D1 p v5 D1N5819
C1 v5 0 470u
Iload v5 0 0
.dc Iload 0 0.8 0.01

.model BAT85 D(IS=1.3e-8 N=1.1 RS=2 CJO=10p BV=30 IBV=2u)
.model D1N5819 D(IS=31.7u N=1.373 RS=0.051 CJO=110p M=0.35 EG=0.69 XTI=2 BV=40 IBV=1m)

.options device temp=27 tnom=27
.options timeint reltol=1e-6 abstol=1e-12
.print DC format=csv precision=12 file=alim_5_0.xy.csv I(Iload) v(v5)
.end
